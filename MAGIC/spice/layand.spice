* SPICE3 file created from layand.ext - technology: scmos

.option scale=0.09u

M1000 s b a Gnd nfet w=10 l=2
+  ad=100 pd=60 as=50 ps=30
M1001 s a_252_18# a w_283_44# pfet w=20 l=2
+  ad=100 pd=50 as=100 ps=50
M1002 s a_252_18# gnd Gnd nfet w=10 l=2
+  ad=0 pd=0 as=100 ps=60
M1003 a_252_18# b a_245_53# w_236_42# pfet w=20 l=2
+  ad=100 pd=50 as=100 ps=50
M1004 a_252_18# b gnd Gnd nfet w=10 l=2
+  ad=50 pd=30 as=0 ps=0
