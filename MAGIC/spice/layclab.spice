* SPICE3 file created from layclab.ext - technology: scmos

.option scale=0.09u

M1000 c4 layc4_0/c4bar gnd Gnd nfet w=10 l=2
+  ad=50 pd=30 as=2175 ps=1120
M1001 c4 layc4_0/c4bar vdd layc4_0/inverterl_0/w_n17_n22# pfet w=20 l=2
+  ad=100 pd=50 as=5450 ps=2410
M1002 vdd p4 layc4_0/a_n42_n27# layc4_0/w_n108_n41# pfet w=50 l=2
+  ad=0 pd=0 as=1250 ps=530
M1003 vdd p4 layc4_0/a_7_n27# layc4_0/w_n108_n41# pfet w=33 l=2
+  ad=0 pd=0 as=1165 ps=496
M1004 layc4_0/a_n94_n27# p4 vdd layc4_0/w_n108_n41# pfet w=100 l=2
+  ad=1500 pd=630 as=0 ps=0
M1005 layc4_0/a_n42_n27# p4 layc4_0/a_n94_n27# layc4_0/w_n108_n41# pfet w=100 l=2
+  ad=0 pd=0 as=0 ps=0
M1006 layc4_0/a_7_n27# p4 layc4_0/a_n42_n27# layc4_0/w_n108_n41# pfet w=100 l=2
+  ad=0 pd=0 as=0 ps=0
M1007 vdd p4 layc4_0/a_n94_n27# layc4_0/w_n108_n41# pfet w=100 l=2
+  ad=0 pd=0 as=0 ps=0
M1008 gnd p4 layc4_0/a_n67_n164# Gnd nfet w=25 l=2
+  ad=0 pd=0 as=625 ps=280
M1009 layc4_0/a_30_n129# p4 layc4_0/a_n14_n149# Gnd nfet w=50 l=2
+  ad=565 pd=256 as=580 ps=262
M1010 layc4_0/c4bar p4 layc4_0/a_30_n129# Gnd nfet w=50 l=2
+  ad=300 pd=140 as=0 ps=0
M1011 gnd p4 layc4_0/a_n14_n149# Gnd nfet w=16 l=2
+  ad=0 pd=0 as=0 ps=0
M1012 layc4_0/a_n94_n174# p4 gnd Gnd nfet w=50 l=2
+  ad=500 pd=220 as=0 ps=0
M1013 layc4_0/a_n67_n164# p4 layc4_0/a_n94_n174# Gnd nfet w=50 l=2
+  ad=0 pd=0 as=0 ps=0
M1014 layc4_0/a_51_n27# p4 layc4_0/a_7_n27# layc4_0/w_n108_n41# pfet w=100 l=2
+  ad=1125 pd=480 as=0 ps=0
M1015 gnd p4 layc4_0/a_30_n129# Gnd nfet w=13 l=2
+  ad=0 pd=0 as=0 ps=0
M1016 layc4_0/a_n14_n149# p4 layc4_0/a_n67_n164# Gnd nfet w=50 l=2
+  ad=0 pd=0 as=0 ps=0
M1017 layc4_0/c4bar p4 layc4_0/a_51_n27# layc4_0/w_n108_n41# pfet w=100 l=2
+  ad=500 pd=210 as=0 ps=0
M1018 vdd p4 layc4_0/a_51_n27# layc4_0/w_n108_n41# pfet w=25 l=2
+  ad=0 pd=0 as=0 ps=0
M1019 gnd p4 layc4_0/c4bar Gnd nfet w=10 l=2
+  ad=0 pd=0 as=0 ps=0
M1020 c2 layc2_0/c2bar gnd Gnd nfet w=10 l=2
+  ad=50 pd=30 as=0 ps=0
M1021 c2 layc2_0/c2bar vdd layc2_0/inverterl_0/w_n17_n22# pfet w=20 l=2
+  ad=100 pd=50 as=0 ps=0
M1022 layc2_0/a_202_n71# p4 vdd layc2_0/w_185_n97# pfet w=60 l=2
+  ad=900 pd=390 as=0 ps=0
M1023 gnd p4 layc2_0/c2bar Gnd nfet w=10 l=2
+  ad=0 pd=0 as=200 ps=100
M1024 layc2_0/c2bar p4 layc2_0/a_235_n179# Gnd nfet w=30 l=2
+  ad=0 pd=0 as=375 ps=180
M1025 layc2_0/a_270_n71# p4 layc2_0/a_202_n71# layc2_0/w_185_n97# pfet w=60 l=2
+  ad=750 pd=330 as=0 ps=0
M1026 layc2_0/c2bar p4 layc2_0/a_270_n71# layc2_0/w_185_n97# pfet w=60 l=2
+  ad=300 pd=130 as=0 ps=0
M1027 layc2_0/a_235_n179# p4 layc2_0/a_202_n189# Gnd nfet w=30 l=2
+  ad=0 pd=0 as=300 ps=140
M1028 vdd p4 layc2_0/a_202_n71# layc2_0/w_185_n97# pfet w=60 l=2
+  ad=0 pd=0 as=0 ps=0
M1029 layc2_0/a_202_n189# p4 gnd Gnd nfet w=30 l=2
+  ad=0 pd=0 as=0 ps=0
M1030 gnd p4 layc2_0/a_235_n179# Gnd nfet w=15 l=2
+  ad=0 pd=0 as=0 ps=0
M1031 vdd p4 layc2_0/a_270_n71# layc2_0/w_185_n97# pfet w=30 l=2
+  ad=0 pd=0 as=0 ps=0
M1032 layc5_0/inv_0/invo layc5_0/inv_0/invi gnd Gnd nfet w=10 l=2
+  ad=50 pd=30 as=0 ps=0
M1033 layc5_0/inv_0/invo layc5_0/inv_0/invi vdd layc5_0/inv_0/w_n17_n22# pfet w=20 l=2
+  ad=100 pd=50 as=0 ps=0
M1034 layc5_0/k p4 vdd layc5_0/w_n23_n72# pfet w=80 l=2
+  ad=1200 pd=510 as=0 ps=0
M1035 layc5_0/a_62_n269# p4 gnd Gnd nfet w=13 l=2
+  ad=465 pd=216 as=0 ps=0
M1036 layc5_0/a_164_n231# p4 gnd Gnd nfet w=10 l=2
+  ad=450 pd=210 as=0 ps=0
M1037 layc5_0/a_213_10# m1_n27_514# layc5_0/a_188_n34# layc5_0/w_n23_n72# pfet w=26 l=2
+  ad=130 pd=62 as=930 ps=402
M1038 layc5_0/inv_0/invi m1_n20_505# layc5_0/a_188_n34# layc5_0/w_n23_n72# pfet w=80 l=2
+  ad=400 pd=170 as=0 ps=0
M1039 layc5_0/l p4 layc5_0/k layc5_0/w_n23_n72# pfet w=80 l=2
+  ad=1000 pd=430 as=0 ps=0
M1040 layc5_0/inv_0/invi m1_n20_505# gnd Gnd nfet w=10 l=2
+  ad=250 pd=120 as=0 ps=0
M1041 vdd p4 layc5_0/m layc5_0/w_n23_n72# pfet w=26 l=2
+  ad=0 pd=0 as=930 ps=402
M1042 vdd p4 layc5_0/l layc5_0/w_n23_n72# pfet w=40 l=2
+  ad=0 pd=0 as=0 ps=0
M1043 layc5_0/a_112_n232# p4 layc5_0/a_62_n269# Gnd nfet w=40 l=2
+  ad=450 pd=210 as=0 ps=0
M1044 layc5_0/a_18_n248# p4 gnd Gnd nfet w=20 l=2
+  ad=500 pd=230 as=0 ps=0
M1045 layc5_0/a_112_n232# p4 gnd Gnd nfet w=10 l=2
+  ad=0 pd=0 as=0 ps=0
M1046 layc5_0/a_62_n269# p4 layc5_0/a_18_n248# Gnd nfet w=40 l=2
+  ad=0 pd=0 as=0 ps=0
M1047 vdd p4 layc5_0/k layc5_0/w_n23_n72# pfet w=80 l=2
+  ad=0 pd=0 as=0 ps=0
M1048 layc5_0/m p4 layc5_0/l layc5_0/w_n23_n72# pfet w=80 l=2
+  ad=0 pd=0 as=0 ps=0
M1049 layc5_0/a_164_9# p4 layc5_0/a_139_n35# layc5_0/w_n23_n72# pfet w=26 l=2
+  ad=130 pd=62 as=930 ps=402
M1050 layc5_0/inv_0/invi m1_n27_514# layc5_0/a_164_n231# Gnd nfet w=40 l=2
+  ad=0 pd=0 as=0 ps=0
M1051 layc5_0/a_164_n231# p4 layc5_0/a_112_n232# Gnd nfet w=40 l=2
+  ad=0 pd=0 as=0 ps=0
M1052 layc5_0/a_18_n248# p4 layc5_0/a_n8_n248# Gnd nfet w=40 l=2
+  ad=0 pd=0 as=400 ps=180
M1053 layc5_0/a_139_n35# p4 layc5_0/m layc5_0/w_n23_n72# pfet w=80 l=2
+  ad=0 pd=0 as=0 ps=0
M1054 layc5_0/a_n8_n248# p4 gnd Gnd nfet w=40 l=2
+  ad=0 pd=0 as=0 ps=0
M1055 layc5_0/a_188_n34# p4 layc5_0/a_139_n35# layc5_0/w_n23_n72# pfet w=80 l=2
+  ad=0 pd=0 as=0 ps=0
M1056 c3 layc3_0/n gnd Gnd nfet w=10 l=2
+  ad=50 pd=30 as=0 ps=0
M1057 c3 layc3_0/n vdd layc3_0/inv_0/w_n17_n22# pfet w=20 l=2
+  ad=100 pd=50 as=0 ps=0
M1058 layc3_0/k p4 vdd layc3_0/w_n23_n72# pfet w=80 l=2
+  ad=1200 pd=510 as=0 ps=0
M1059 layc3_0/a_62_n211# p4 gnd Gnd nfet w=13 l=2
+  ad=465 pd=216 as=0 ps=0
M1060 layc3_0/l p4 layc3_0/k layc3_0/w_n23_n72# pfet w=80 l=2
+  ad=1000 pd=430 as=0 ps=0
M1061 vdd p4 layc3_0/m layc3_0/w_n23_n72# pfet w=26 l=2
+  ad=0 pd=0 as=930 ps=402
M1062 vdd p4 layc3_0/l layc3_0/w_n23_n72# pfet w=40 l=2
+  ad=0 pd=0 as=0 ps=0
M1063 layc3_0/n p4 gnd Gnd nfet w=10 l=2
+  ad=250 pd=120 as=0 ps=0
M1064 layc3_0/a_62_n211# p4 layc3_0/p Gnd nfet w=40 l=2
+  ad=0 pd=0 as=500 ps=230
M1065 vdd p4 layc3_0/k layc3_0/w_n23_n72# pfet w=80 l=2
+  ad=0 pd=0 as=0 ps=0
M1066 layc3_0/m p4 layc3_0/l layc3_0/w_n23_n72# pfet w=80 l=2
+  ad=0 pd=0 as=0 ps=0
M1067 layc3_0/n p4 layc3_0/m layc3_0/w_n23_n72# pfet w=80 l=2
+  ad=400 pd=170 as=0 ps=0
M1068 layc3_0/p p4 layc3_0/q Gnd nfet w=40 l=2
+  ad=0 pd=0 as=400 ps=180
M1069 layc3_0/q p4 gnd Gnd nfet w=40 l=2
+  ad=0 pd=0 as=0 ps=0
M1070 layc3_0/p p4 gnd Gnd nfet w=20 l=2
+  ad=0 pd=0 as=0 ps=0
M1071 layc3_0/n p4 layc3_0/a_62_n211# Gnd nfet w=40 l=2
+  ad=0 pd=0 as=0 ps=0
M1072 c1 layc1_0/c1bar gnd Gnd nfet w=10 l=2
+  ad=50 pd=30 as=0 ps=0
M1073 c1 layc1_0/c1bar vdd layc1_0/inverterl_0/w_n17_n22# pfet w=20 l=2
+  ad=100 pd=50 as=0 ps=0
M1074 layc1_0/a_1_365# p4 vdd layc1_0/w_n13_353# pfet w=40 l=2
+  ad=600 pd=270 as=0 ps=0
M1075 layc1_0/a_1_293# p4 gnd Gnd nfet w=20 l=2
+  ad=200 pd=100 as=0 ps=0
M1076 layc1_0/c1bar p4 layc1_0/a_1_365# layc1_0/w_n13_353# pfet w=40 l=2
+  ad=61 pd=30 as=0 ps=0
M1077 gnd p4 layc1_0/c1bar Gnd nfet w=10 l=2
+  ad=0 pd=0 as=150 ps=80
M1078 vdd p4 layc1_0/a_1_365# layc1_0/w_n13_353# pfet w=40 l=2
+  ad=0 pd=0 as=0 ps=0
M1079 layc1_0/c1bar p4 layc1_0/a_1_293# Gnd nfet w=20 l=2
+  ad=0 pd=0 as=0 ps=0
C0 m1_n27_514# m1_n20_505# 2.96fF
C1 p4 layc5_0/w_n23_n72# 3.02fF
C2 p4 layc4_0/w_n108_n41# 2.12fF
C3 p4 layc3_0/w_n23_n72# 2.26fF
C4 vdd layc4_0/a_n94_n27# 2.24fF
C5 p4 m1_n27_514# 3.45fF
C6 vdd p4 6.08fF
C7 p4 Gnd 133.09fF
C8 gnd Gnd 13.19fF
C9 vdd Gnd 19.04fF
C10 layc2_0/w_185_n97# Gnd 18.91fF
C11 layc4_0/w_n108_n41# Gnd 26.49fF
