* SPICE3 file created from layc5.ext - technology: scmos

.option scale=0.09u

M1000 inv_0/invo inv_0/invi gnd Gnd nfet w=10 l=2
+  ad=50 pd=30 as=565 ps=296
M1001 inv_0/invo inv_0/invi vdd inv_0/w_n17_n22# pfet w=20 l=2
+  ad=100 pd=50 as=1230 ps=542
M1002 k c0 vdd w_n23_n72# pfet w=80 l=2
+  ad=1200 pd=510 as=0 ps=0
M1003 a_62_n269# g2 gnd Gnd nfet w=13 l=2
+  ad=465 pd=216 as=0 ps=0
M1004 a_164_n231# a_182_n140# gnd Gnd nfet w=10 l=2
+  ad=450 pd=210 as=0 ps=0
M1005 a_213_10# a_207_n148# a_188_n34# w_n23_n72# pfet w=26 l=2
+  ad=130 pd=62 as=930 ps=402
M1006 inv_0/invi a_237_n156# a_188_n34# w_n23_n72# pfet w=80 l=2
+  ad=400 pd=170 as=0 ps=0
M1007 l g1 k w_n23_n72# pfet w=80 l=2
+  ad=1000 pd=430 as=0 ps=0
M1008 inv_0/invi a_237_n156# gnd Gnd nfet w=10 l=2
+  ad=250 pd=120 as=0 ps=0
M1009 vdd p3 m w_n23_n72# pfet w=26 l=2
+  ad=0 pd=0 as=930 ps=402
M1010 vdd p2 l w_n23_n72# pfet w=40 l=2
+  ad=0 pd=0 as=0 ps=0
M1011 a_112_n232# p3 a_62_n269# Gnd nfet w=40 l=2
+  ad=450 pd=210 as=0 ps=0
M1012 a_18_n248# g1 gnd Gnd nfet w=20 l=2
+  ad=500 pd=230 as=0 ps=0
M1013 a_112_n232# g3 gnd Gnd nfet w=10 l=2
+  ad=0 pd=0 as=0 ps=0
M1014 a_62_n269# p2 a_18_n248# Gnd nfet w=40 l=2
+  ad=0 pd=0 as=0 ps=0
M1015 vdd p1 k w_n23_n72# pfet w=80 l=2
+  ad=0 pd=0 as=0 ps=0
M1016 m g2 l w_n23_n72# pfet w=80 l=2
+  ad=0 pd=0 as=0 ps=0
M1017 a_164_9# a_158_n132# a_139_n35# w_n23_n72# pfet w=26 l=2
+  ad=130 pd=62 as=930 ps=402
M1018 inv_0/invi a_207_n148# a_164_n231# Gnd nfet w=40 l=2
+  ad=0 pd=0 as=0 ps=0
M1019 a_164_n231# a_158_n132# a_112_n232# Gnd nfet w=40 l=2
+  ad=0 pd=0 as=0 ps=0
M1020 a_18_n248# p1 a_n8_n248# Gnd nfet w=40 l=2
+  ad=0 pd=0 as=400 ps=180
M1021 a_139_n35# g3 m w_n23_n72# pfet w=80 l=2
+  ad=0 pd=0 as=0 ps=0
M1022 a_n8_n248# c0 gnd Gnd nfet w=40 l=2
+  ad=0 pd=0 as=0 ps=0
M1023 a_188_n34# a_182_n140# a_139_n35# w_n23_n72# pfet w=80 l=2
+  ad=0 pd=0 as=0 ps=0
C0 a_182_n140# a_158_n132# 2.42fF
C1 a_237_n156# a_207_n148# 2.92fF
C2 a_182_n140# a_207_n148# 2.66fF
C3 a_158_n132# g3 2.16fF
C4 gnd Gnd 4.35fF
