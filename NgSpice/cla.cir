.include TSMC_180nm.txt
.param SUPPLY=1.8
.param LAMBDA=0.09u

.param k=0.9u
.param p=3.6u
.param n=3.6u

vdd vdd gnd DC 1.8

.subckt nmos d g s b W='N'
.param width_N={W}
M1 d g s b CMOSN W={width_N} L={2*LAMBDA}
+ AS={5*width_N*LAMBDA} PS={10*LAMBDA+2*width_N} AD={5*width_N*LAMBDA} PD={10*LAMBDA+2*width_N}
.ends nmos

.subckt pmos d g s b W='P'
.param width_P={W}
M1 d g s b CMOSP W={width_P} L={2*LAMBDA}
+ AS={5*width_P*LAMBDA} PS={10*LAMBDA+2*width_P} AD={5*width_P*LAMBDA} PD={10*LAMBDA+2*width_P}
.ends pmos

.subckt inv out in vdd gnd N='a'
.param width_N={N}
.param width_P={2*width_N}
M1 out in gnd gnd CMOSN W={width_N} L={2*LAMBDA}
+ AS={5*width_N*LAMBDA} PS={10*LAMBDA+2*width_N} AD={5*width_N*LAMBDA} PD={10*LAMBDA+2*width_N}
M2 out in vdd vdd CMOSP W={width_P} L={2*LAMBDA}
+ AS={5*width_P*LAMBDA} PS={10*LAMBDA+2*width_P} AD={5*width_P*LAMBDA} PD={10*LAMBDA+2*width_P}
.ends inv

.subckt dff out d clk vdd gnd
x1 m23 d vdd vdd pmos W='20*LAMBDA'
x2 m12 clk m23 m23 pmos W='20*LAMBDA'
x3 m12 d gnd gnd nmos W='10*LAMBDA'
x4 m56 clk vdd vdd pmos W='20*LAMBDA'
x5 m56 m12 m45 m45 nmos W='10*LAMBDA'
x6 m45 clk gnd gnd nmos W='10*LAMBDA'
x7 m89 m56 vdd vdd pmos W='20*LAMBDA'
x8 m89 clk m78 m78 nmos W='10*LAMBDA'
x9 m78 m56 gnd gnd nmos W='10*LAMBDA'
x10 out m89 vdd gnd inv N='10*LAMBDA'
.ends dff

.subckt and out a b bbar vdd gnd
x1 a b out gnd nmos W='10*LAMBDA'
x2 out bbar a vdd pmos W='20*LAMBDA'
x3 out bbar gnd gnd nmos W='10*LAMBDA'
.ends and

.subckt xor out a b bbar vdd gnd
x1 out b a vdd pmos W='20*LAMBDA'
x2 a bbar out gnd nmos W='10*LAMBDA'
x3 bbar a out gnd nmos W='10*LAMBDA'
x4 out a b vdd pmos W='20*LAMBDA'
.ends xor

x43 a0 a0in clk_org vdd gnd dff
x44 a1 a1in clk_org vdd gnd dff
x45 a2 a2in clk_org vdd gnd dff
x46 a3 a3in clk_org vdd gnd dff
x46b a4 a4in clk_org vdd gnd dff

x47 b0 b0in clk_org vdd gnd dff
x48 b1 b1in clk_org vdd gnd dff
x49 b2 b2in clk_org vdd gnd dff
x50 b3 b3in clk_org vdd gnd dff
x50b b4 b4in clk_org vdd gnd dff

x95 cinin cin clk_org vdd gnd dff

x80 b0bar b0 vdd gnd inv N='10*LAMBDA'
x81 b1bar b1 vdd gnd inv N='10*LAMBDA'
x82 b2bar b2 vdd gnd inv N='10*LAMBDA'
x83 b3bar b3 vdd gnd inv N='10*LAMBDA'
x83b b4bar b4 vdd gnd inv N='10*LAMBDA'

x471 p0 a0 b0 b0bar vdd gnd xor
x431 g0 a0 b0 b0bar vdd gnd and

x481 p1 a1 b1 b1bar vdd gnd xor
x441 g1 a1 b1 b1bar vdd gnd and

x491 p2 a2 b2 b2bar vdd gnd xor
x451 g2 a2 b2 b2bar vdd gnd and

x501 p3 a3 b3 b3bar vdd gnd xor
x461 g3 a3 b3 b3bar vdd gnd and

x501b p4 a4 b4 b4bar vdd gnd xor
x461b g4 a4 b4 b4bar vdd gnd and

x_c4_1 c4bar clk vdd vdd pmos W='p'u
x_c4_2 c4bar p4 m_c4_a m_c4_a nmos W='n'u
x_c4_3 m_c4_a p3 m_c4_b m_c4_b nmos W='n'u
x_c4_4 m_c4_b p2 m_c4_c m_c4_c nmos W='n'u
x_c4_5 m_c4_c p1 m_c4_d m_c4_d nmos W='n'u
x_c4_6 m_c4_d p0 m_c4_e m_c4_e nmos W='n'u
x_c4_7 m_c4_e cin m_c4_f m_c4_f nmos W='n'u
x_c4_8 m_c4_f clk gnd gnd nmos W='n'u
x_c4_g4 c4bar g4 m_c4_f m_c4_f nmos W='n'u
x_c4_g3 m_c4_a g3 m_c4_f m_c4_f nmos W='n'u
x_c4_g2 m_c4_b g2 m_c4_f m_c4_f nmos W='n'u
x_c4_g1 m_c4_c g1 m_c4_f m_c4_f nmos W='n'u
x_c4_g0 m_c4_d g0 m_c4_f m_c4_f nmos W='n'u

x1 c3bar clk vdd vdd pmos W='p'u
x2 c3bar p3 m23 m23 nmos W='n'u
x3 m23 p2 m34 m34 nmos W='n'u
x4 m34 p1 m45 m45 nmos W='n'u
x5 m45 p0 m56 m56 nmos W='n'u
x6 m56 cin m67 m67 nmos W='n'u
x7 m67 clk gnd gnd nmos W='n'u
x8 m45 g0 m67 m67 nmos W='n'u
x9 m34 g1 m67 m67 nmos W='n'u
x10 m23 g2 m67 m67 nmos W='n'u
x11 c3bar g3 m67 m67 nmos W='n'u

x12 c2bar clk vdd vdd pmos W='p'u
x13 c2bar p2 n34 n34 nmos W='n'u
x14 n34 p1 n45 n45 nmos W='n'u
x15 n45 p0 n56 n56 nmos W='n'u
x16 n56 cin n67 n67 nmos W='n'u
x17 n67 clk gnd gnd nmos W='n'u
x18 n45 g0 n67 n67 nmos W='n'u
x19 n34 g1 n67 n67 nmos W='n'u
x20 c2bar g2 n67 n67 nmos W='n'u

x21 c1bar clk vdd vdd pmos W='p'u
x22 c1bar p1 o45 o45 nmos W='n'u
x23 o45 p0 o56 o56 nmos W='n'u
x24 o56 cin o67 o67 nmos W='n'u
x25 o67 clk gnd gnd nmos W='n'u
x26 o45 g0 o67 o67 nmos W='n'u
x27 c1bar g1 o67 o67 nmos W='n'u

x28 c0bar clk vdd vdd pmos W='p'u
x29 c0bar p0 p56 p56 nmos W='n'u
x30 p56 cin p67 p67 nmos W='n'u
x31 p67 clk gnd gnd nmos W='n'u
x33 c0bar g0 p67 p67 nmos W='n'u

x34 c0 c0bar vdd gnd inv N='10*LAMBDA'
x35 c1 c1bar vdd gnd inv N='10*LAMBDA'
x36 c2 c2bar vdd gnd inv N='10*LAMBDA'
x37 c3 c3bar vdd gnd inv N='10*LAMBDA'
x37b c4 c4bar vdd gnd inv N='10*LAMBDA'

x39 c0bar c0 vdd vdd pmos W='k'u
x40 c1bar c1 vdd vdd pmos W='k'u
x41 c2bar c2 vdd vdd pmos W='k'u
x42 c3bar c3 vdd vdd pmos W='k'u
x42b c4bar c4 vdd vdd pmos W='k'u

x1000 clk clk_org vdd gnd inv N='20*LAMBDA'
x84 cinbar cin vdd gnd inv N='10*LAMBDA'

x472 s0in p0 cin cinbar vdd gnd xor
x482 s1in p1 c0 c0bar vdd gnd xor
x492 s2in p2 c1 c1bar vdd gnd xor
x502 s3in p3 c2 c2bar vdd gnd xor
x502b s4in p4 c3 c3bar vdd gnd xor

x433 s0 s0in clk_org vdd gnd dff
x443 s1 s1in clk_org vdd gnd dff
x453 s2 s2in clk_org vdd gnd dff
x463 s3 s3in clk_org vdd gnd dff
x463b s4 s4in clk_org vdd gnd dff
x464 cout c4 clk_org vdd gnd dff

x_load_s0 s0_load s0 vdd gnd inv N='10*LAMBDA'
x_load_s1 s1_load s1 vdd gnd inv N='10*LAMBDA'
x_load_s2 s2_load s2 vdd gnd inv N='10*LAMBDA'
x_load_s3 s3_load s3 vdd gnd inv N='10*LAMBDA'
x_load_s4 s4_load s4 vdd gnd inv N='10*LAMBDA'
x_load_cout cout_load cout vdd gnd inv N='10*LAMBDA'

.param Ton=2n
.param Tperiod={2*Ton}
V_clk_org clk_org 0 pulse(0 1.8 {0.3*Ton} 10p 10p {Ton} {Tperiod})
V9 cinin 0 0

V1 a0in 0 pulse(0 1.8 0 10p 10p {2*Ton} {4*Ton})
v2 a1in 0 pulse(0 1.8 0 10p 10p {3*Ton} {6*Ton})
v3 a2in 0 pulse(0 1.8 0 10p 10p {4*Ton} {8*Ton})
v4 a3in 0 pulse(0 1.8 0 10p 10p {5*Ton} {10*Ton})
v4b a4in 0 pulse(0 1.8 0 10p 10p {6*Ton} {12*Ton})

V5 b0in 0 pulse(0 1.8 0 10p 10p {7*Ton} {14*Ton})
v6 b1in 0 pulse(0 1.8 0 10p 10p {8*Ton} {16*Ton})
v7 b2in 0 pulse(0 1.8 0 10p 10p {9*Ton} {18*Ton})
v8 b3in 0 pulse(0 1.8 0 10p 10p {10*Ton} {20*Ton})
v8b b4in 0 pulse(0 1.8 0 10p 10p {11*Ton} {22*Ton})

.tran 0.05n {30*Ton}

.control
run
set hcopypscolor = 1
set color0 = white
set curplottitle= "Mounika_2024102006_Q3_CLA_SUM"
plot v(s0) 2+v(s1) 4+v(s2) 6+v(s3) 8+v(s4) 10+v(clk_org)
set curplottitle= "Mounika_2024102006_Q3_CLA_Cout"
plot v(cout)
plot V1

meas tran t_pd_cout trig v(clk_org) val=0.9 rise=2 targ v(cout) val=0.9 rise=1

meas tran t_pd_sum4 trig v(clk_org) val=0.9 rise=2 targ v(s4) val=0.9 rise=1

.endc
